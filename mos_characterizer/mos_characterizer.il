; MOS Characterizer. MIT License. No foundry data is included.
mcToolDir=strcat(getShellEnvVar("HOME") "/ic/mos_characterizer")
mcRegistryFile=strcat(mcToolDir "/registry.il")
unless(boundp('mcRegistry) mcRegistry=nil)
unless(boundp('mcCreating) mcCreating=nil)
procedure(mcRequire(v msg) unless(v error("MOS Characterizer: %s\n" msg)) v)
procedure(mcEntry(name) assoc(name mcRegistry))
procedure(mcPersist()
 let((p) mcRequire(isDir(mcToolDir) "Install in ~/ic/mos_characterizer")
 p=outfile(mcRegistryFile) mcRequire(p "Cannot write template registry")
 fprintf(p "mcRegistry='%L\n" mcRegistry) close(p)))
procedure(mcSavedc(lib)
 let((path p line extra)
 path=strcat(ddGetObj(lib)~>readPath "/savedc.scs")
 if(isFile(path) then
 p=infile(path) gets(line p) gets(extra p) close(p)
 mcRequire(member(line '("save M0:all\n" "save M0:all")) "Existing savedc.scs differs; not overwritten")
 mcRequire(null(extra) "savedc.scs has extra lines; not overwritten")
 else p=outfile(path) mcRequire(p "Cannot create savedc.scs") fprintf(p "save M0:all\n") close(p))
 path))
procedure(mcParseModels(text)
 let((models parts)
 models=nil
 foreach(line parseString(text "\n") parts=parseString(line "|")
 when(parts mcRequire(length(parts)<=2 "Use one model file|section per line")
 mcRequire(isFile(car(parts)) strcat("Model not found: " car(parts))) models=append(models list(parts))))
 models))

unless(boundp('mcSavedModels) mcSavedModels=nil)
unless(boundp('mcModelSource) mcModelSource="Reuse saved models")
unless(boundp('mcModelTest) mcModelTest="")
procedure(mcModelSources()
 let((items) items=list("Reuse saved models")
 foreach(lib ddGetLibList() foreach(cell lib~>cells foreach(v cell~>views
 when(rexMatchp("^maestro" v~>name) items=append(items list(strcat(lib~>name "/" cell~>name "/" v~>name))))))) items))
procedure(mcReadModelSetup(source)
 let((parts mcSessionId tests previous)
 parts=parseString(source "/") mcRequire(length(parts)==3 "Choose a source Maestro")
 mcRequire(ddGetObj(car(parts) cadr(parts) caddr(parts)) "Model-source Maestro does not exist")
 previous=maeGetSessions()
 mcSessionId=maeOpenSetup(car(parts) cadr(parts) caddr(parts) ?mode "r")
 mcRequire(mcSessionId "Cannot open model-source Maestro read-only")
 tests=maeGetSetup(?session mcSessionId)
 mcRequire(tests "Model-source Maestro has no tests") list(mcSessionId tests !member(mcSessionId previous))))
procedure(mcReleaseModelSetup(info)
 when(nth(2 info) maeCloseSession(?session car(info))))
procedure(mcModelSourceChanged()
 let((source info tests)
 source=mcBatchForm->modelsource->value
 if(source=="Reuse saved models" then tests=list("")
 else info=mcReadModelSetup(source) tests=cadr(info) mcReleaseModelSetup(info))
 mcBatchForm->modeltest->choices=tests
 mcBatchForm->modeltest->value=if(member(mcModelTest tests) then mcModelTest else car(tests))))
procedure(mcStoreModels(models source mcTestName)
 let((p)
 mcSavedModels=copy(models) mcModelSource=source mcModelTest=mcTestName
 p=outfile(strcat(mcToolDir "/model-defaults.il")) mcRequire(p "Cannot save model preferences")
 fprintf(p "mcSavedModels='%L\nmcModelSource=%L\nmcModelTest=%L\n" models source mcTestName) close(p)
 copy(models)))
procedure(mcResolveSavedModels()
 let((choices firstSource firstTest info models result)
 when(isFile(strcat(mcToolDir "/model-defaults.il"))
 load(strcat(mcToolDir "/model-defaults.il")))
 unless(mcSavedModels
 choices=nil
 foreach(source cdr(mcModelSources())
 result=errset(mcReadModelSetup(source) nil)
 when(result info=car(result)
 foreach(mcTestName cadr(info)
 result=errset(maeGetEnvOption(mcTestName ?option "modelFiles" ?session car(info)) nil)
 when(result
 models=setof(m car(result) !rexMatchp("savedc[.]scs$" car(m)))
 when(models && !member(models choices)
 choices=append(choices list(models))
 unless(firstSource firstSource=source firstTest=mcTestName))))
 mcReleaseModelSetup(info)))
 mcRequire(choices "No saved models and no configured source Maestro found. Choose a Maestro with PDK model files.")
 mcRequire(length(choices)==1 "Several different model configurations found. Select the matching source Maestro and test once.")
 mcStoreModels(car(choices) firstSource firstTest))
 mcRequire(mcSavedModels "Model cache is empty") copy(mcSavedModels)))
procedure(mcImportModels(source mcTestName)
 let((info models p)
 if(source=="Reuse saved models" then models=mcResolveSavedModels()
 else
 info=mcReadModelSetup(source)
 mcRequire(member(mcTestName cadr(info)) "Choose a test from the source Maestro")
 models=maeGetEnvOption(mcTestName ?option "modelFiles" ?session car(info))
 mcReleaseModelSetup(info)
 ; Never reuse the old library's savedc include.
 models=setof(m models !rexMatchp("savedc[.]scs$" car(m)))
 mcRequire(models "Selected test has no PDK model files")
 mcSavedModels=copy(models) mcModelSource=source mcModelTest=mcTestName
 p=outfile(strcat(mcToolDir "/model-defaults.il")) mcRequire(p "Cannot save model-source preferences")
 fprintf(p "mcSavedModels='%L\nmcModelSource=%L\nmcModelTest=%L\n" models source mcTestName) close(p)) mcRequire(models "Model import returned no PDK models") models))

procedure(mcValidate(cv polarity) cv)

procedure(mcTemplate(name)
 let((e cv) e=mcEntry(name) mcRequire(e "Reference not registered")
 cv=dbOpenCellViewByType(nth(2 e) nth(3 e) nth(4 e) "" "r")
 mcRequire(cv "Source cellview cannot be opened") cv))

procedure(mcAfterSave(cv @rest extra)
 when(!mcCreating && mcRegistry
 foreach(e mcRegistry
 when(cv~>libName==nth(2 e) && cv~>cellName==nth(3 e) && cv~>viewName==nth(4 e)
 errset(mcSavedc(cv~>libName) t)))) t)

procedure(mcOpenReference(lib cell view)
 hiRegTimer(sprintf(nil "deOpenCellView(%L %L %L \"schematic\" nil \"a\")" lib cell view) 1))
procedure(mcCreateReference(name polarity deviceLib deviceCell storeLib storeCell view models @optional (openEditor t))
 let((cv entry mcCreating key)
 key=strcat(storeLib "/" storeCell "/" view)
 mcRequire(!mcEntry(key) "This cellview is already registered")
 mcRequire(ddGetObj(storeLib) "Choose an existing storage library")
 mcRequire(!ddGetObj(storeLib storeCell view) "Source cellview already exists")
 cv=dbOpenCellViewByType(storeLib storeCell view "schematic" "a")
 mcRequire(cv "Cannot create blank schematic")
 entry=list(key nil storeLib storeCell view models t nil nil)
 mcRegistry=append(mcRegistry list(entry)) mcPersist()
 mcCreating=t dbSave(cv) mcCreating=nil
 when(openEditor mcOpenReference(storeLib storeCell view)) cv))

procedure(mcReadyNames() foreach(mapcar e mcRegistry car(e)))

procedure(mcDestinationCell(e)
 if(boundp('mcTargetCell) && mcTargetCell && mcTargetCell!="" then mcTargetCell else nth(3 e)))
procedure(mcPreflight(lib names prefix)
 mcRequire(ddGetObj(lib) "Choose an existing target library")
 mcRequire(names "Select at least one reference")
 foreach(name names let((e av)
 e=mcEntry(name) mcTemplate(name)
 mcRequire((boundp('mcModelOverride) && mcModelOverride) || nth(5 e) "No PDK model files configured. Select a source Maestro with PDK models before creating Maestro.")
 av=strcat("maestro_" nth(4 e))
 mcRequire(!ddGetObj(lib mcDestinationCell(e) nth(4 e)) "Target source view already exists; no overwrite")
 mcRequire(!ddGetObj(lib mcDestinationCell(e) av) "Target Maestro already exists; no overwrite"))) t)

procedure(mcBatchGenerate(lib names prefix voltage lval wval)
 let((made e)
 mcPreflight(lib names prefix) mcSavedc(lib) made=nil
 foreach(name names e=mcEntry(name)
 mcDoGenerate(lib mcDestinationCell(e) nth(4 e) strcat("maestro_" nth(4 e)) name voltage lval wval)
 made=append(made list(strcat(lib "/" mcDestinationCell(e) "/" nth(4 e))))) made))

procedure(mcBatchCallback()
 let((f result mcTargetCell mcModelOverride) f=mcBatchForm
 mcTargetCell=f->targetcell->value mcModelOverride=mcImportModels(f->modelsource->value f->modeltest->value)
 mcRequire(mcTargetCell=="" || length(f->refs->value)==1 "To specify a target cell, select exactly one reference")
 result=errset(mcBatchGenerate(f->lib->value f->refs->value "" f->vdd->value f->lval->value f->wval->value) t)
 when(result
 foreach(name f->refs->value rplaca(nthcdr(5 mcEntry(name)) copy(mcModelOverride)))
 mcPersist())
 f->status->value=if(result then strcat("Created: " buildString(car(result) ", ")) else "Failed; see CIW. Existing cells are not overwritten; new partial cells may remain.")))
procedure(mcLibChoices() sort(ddGetLibList()~>name 'alphalessp))
procedure(mcCellChoices(lib)
 let((cells) cells=sort(ddGetObj(lib)~>cells~>name 'alphalessp) if(cells then cells else list(""))))
procedure(mcBlankCreate()
 let((f models)
 f=mcBlankForm models=nil
 mcCreateReference("" nil nil nil f->lib->value f->cell->value f->view->value models)
 f->status->value="Blank cellview created and registered. Draw freely and save."))
procedure(mcFirstUse() mcAddReference())
procedure(mcValidateReferences() mcReadyNames())
procedure(mcDoGenerate(lib cell sv av kind vdd lval wval)
 let((src cv supply mcSessionId mcTestName port path models options outputs)
 mcRequire(ddGetObj(lib) "Select an existing target library")
 mcRequire(cell!="" && sv!="" && av!="" "Cell and view names cannot be empty")
 mcRequire(vdd>=0.1 "Sweep stop must be at least 0.1 V")
 mcRequire(!ddGetObj(lib cell sv) "Target schematic exists; choose a new cell or view")
 mcRequire(!ddGetObj(lib cell av) "Target Maestro exists; choose a new cell or view")
 src=mcTemplate(kind)
 path=strcat(ddGetObj(lib)~>readPath "/savedc.scs")
 when(isFile(path)
 port=infile(path) gets(options port) close(port)
 mcRequire(member(options '("save M0:all\n" "save M0:all")) "Existing savedc.scs differs; it has been preserved"))
 unless(isFile(path)
 port=outfile(path) mcRequire(port "Cannot write savedc.scs") fprintf(port "save M0:all\n") close(port))
 cv=dbCopyCellView(src lib cell sv nil)
 mcRequire(cv "Cannot copy reference schematic")
 dbSave(cv)
 mcSessionId=maeOpenSetup(lib cell av)
 mcRequire(mcSessionId "Cannot create Maestro session")
 mcTestName=strcat(lib ":" cell ":mos_dc")
 mcRequire(maeCreateTest(mcTestName ?lib lib ?cell cell ?view sv ?simulator "spectre" ?session mcSessionId) "Cannot create Maestro test")
 ; ADE Explorer displays test-scoped Design Variables.
 foreach(mcVarPair list(list("L" lval) list("W" wval) list("vin" "0.5"))
 mcRequire(maeSetVar(car(mcVarPair) cadr(mcVarPair) ?session mcSessionId ?typeName "test" ?typeValue list(mcTestName)) "Cannot set Explorer design variable"))
 foreach(mcVarPair list(list("L" lval) list("W" wval) list("vin" "0.5"))
 mcRequire(equal(maeGetVar(car(mcVarPair) ?session mcSessionId ?typeName "test" ?typeValue mcTestName) cadr(mcVarPair)) "Explorer design-variable readback differs"))
 models=append(copy(if(boundp('mcModelOverride) && mcModelOverride then mcModelOverride else nth(5 mcEntry(kind)))) list(list(path)))
 mcRequire(maeSetEnvOption(mcTestName ?options list(list("modelFiles" models)) ?session mcSessionId) "Cannot add global model files")
 options=list(list("saveOppoint" t) list("sweep" "Design Variable") list("designVar" "vin") list("param" "vin") list("rangeType" "Start-Stop") list("start" "0.1") list("stop" sprintf(nil "%g" vdd)) list("incrType" "Linear") list("stepTypeLin" "Step Size") list("step" "0.05"))
 mcRequire(maeSetAnalysis(mcTestName "dc" ?enable t ?options options ?session mcSessionId) "Cannot configure DC analysis")
 outputs='(("gain" "getData(\"M0:self_gain\" ?result \"dc\")") ("id" "getData(\"M0:id\" ?result \"dc\")") ("gmid" "getData(\"M0:gmoverid\" ?result \"dc\")") ("gmid_id" "waveVsWave(?x gmid ?y id)") ("gmid_gain" "waveVsWave(?x gmid ?y gain)"))
 foreach(pair outputs mcRequire(maeAddOutput(car(pair) mcTestName ?outputType "point" ?expr cadr(pair) ?plot t ?save t ?session mcSessionId) strcat("Cannot add " car(pair))))
 mcRequire(maeSaveSetup(?session mcSessionId) "Cannot save Maestro")
 maeCloseSession(?session mcSessionId)
 printf("MOS_TEMPLATE_OK %s/%s/%s; Maestro=%s; type=%s; stop=%g\n" lib cell sv av kind vdd)
 mcSessionId
 ))

procedure(mcAddReference()
 prog((libs)
 when(boundp('mcBlankForm) && mcBlankForm hiDisplayForm(mcBlankForm) return(t))
 libs=mcLibChoices()
 mcBlankForm=hiCreateAppForm(?name 'mcBlankForm ?formTitle "Create a blank reference cellview" ?buttonLayout 'Close ?fields list(
 list(hiCreateCyclicField(?name 'lib ?prompt "Library" ?choices libs ?value car(libs)) 10:10 700:28 220)
 list(hiCreateStringField(?name 'cell ?prompt "Cell" ?value "ref") 10:50 700:28 220)
 list(hiCreateStringField(?name 'view ?prompt "Schematic view" ?value "schematic") 10:90 700:28 220)
 list(hiCreateButton(?name 'create ?buttonText "Create blank schematic" ?callback "errset(mcBlankCreate() t)") 10:230 340:34)
 list(hiCreateButton(?name 'show ?buttonText "Open library installer" ?callback "mcShow()") 370:230 330:34)
 list(hiCreateStringField(?name 'status ?prompt "Status" ?editable nil ?value "No device placement or circuit validation. Add as many cellviews as needed.") 10:280 700:28 65)))
 hiDisplayForm(mcBlankForm)))
procedure(mcRefreshCatalog()
 let((ready) ready=mcReadyNames()
 mcRequire(ready "No registered reference cellviews.")
 mcBatchForm->refs->choices=ready mcBatchForm->refs->value=ready))
procedure(mcShow()
 prog((libs ready)
 unless(mcRegistry mcFirstUse() return(nil))
 ready=mcReadyNames()
 unless(ready printf("Finish and save the reference drawings first. Use mcAddReference() for more devices.\n") mcFirstUse() return(nil))
 when(boundp('mcBatchForm) && mcBatchForm mcRefreshCatalog() hiDisplayForm(mcBatchForm) return(t))
 libs=mcLibChoices()
 mcBatchForm=hiCreateAppForm(?name 'mcBatchForm ?formTitle "MOS Characterizer - Install selected references into a library" ?buttonLayout 'Close ?fields list(
 list(hiCreateCyclicField(?name 'lib ?prompt "Target library" ?choices libs ?value car(libs)) 10:10 700:28 220)
 list(hiCreateListBoxField(?name 'refs ?prompt "Source library/cell/view" ?choices ready ?value ready ?multipleSelect t) 10:50 700:85 220)
 list(hiCreateStringField(?name 'targetcell ?prompt "Target cell (one selection; blank keeps source)" ?value "") 10:145 700:28 300)
 list(hiCreateFloatField(?name 'vdd ?prompt "VDD / sweep stop (V)" ?value 1.8) 10:220 700:28 220)
 list(hiCreateStringField(?name 'lval ?prompt "Default L" ?value "360n") 10:255 700:28 220)
 list(hiCreateStringField(?name 'wval ?prompt "Default W" ?value "1u") 10:290 700:28 220)
 list(hiCreateCyclicField(?name 'modelsource ?prompt "Copy models from Maestro" ?choices mcModelSources() ?value "Reuse saved models" ?callback "mcModelSourceChanged()") 10:330 700:28 220)
 list(hiCreateCyclicField(?name 'modeltest ?prompt "Source test" ?choices list("") ?value "") 10:375 700:28 220)
 list(hiCreateButton(?name 'confirm ?buttonText "Confirm: create selected cells" ?callback "mcBatchCallback()") 10:470 340:34)
 list(hiCreateButton(?name 'add ?buttonText "Add another reference" ?callback "mcAddReference()") 370:470 330:34)
 list(hiCreateButton(?name 'refresh ?buttonText "Refresh saved references" ?callback "mcRefreshCatalog()") 10:515 340:32)
 list(hiCreateStringField(?name 'status ?prompt "Status" ?editable nil ?value "Source cell/view names are preserved. Maestro view: maestro_<source view>. No circuit validation.") 10:560 700:28 65)))
 when(member(mcModelSource mcBatchForm->modelsource->choices) mcBatchForm->modelsource->value=mcModelSource)
 mcModelSourceChanged()
 hiDisplayForm(mcBatchForm)))
when(isFile(mcRegistryFile) load(mcRegistryFile))
; Migrate older registry labels to actual source cellview paths, without changing designs.
foreach(e mcRegistry rplaca(e strcat(nth(2 e) "/" nth(3 e) "/" nth(4 e))))
; Rebuild only the tool installer form when reloading this version.
when(boundp('mcBatchForm) && mcBatchForm hiFormDone(mcBatchForm))
mcBatchForm=nil
when(boundp('mcBlankForm) && mcBlankForm hiFormDone(mcBlankForm))
mcBlankForm=nil
when(isFile(strcat(mcToolDir "/model-defaults.il")) load(strcat(mcToolDir "/model-defaults.il")))

unless(boundp('mcSaveHookInstalled) && mcSaveHookInstalled
 mcRequire(isCallable('dbRegPostSaveTrigger) "This Virtuoso needs dbRegPostSaveTrigger")
 dbRegPostSaveTrigger("mcAfterSave") mcSaveHookInstalled=t)
unless(boundp('mcSuppressDisplay) && mcSuppressDisplay mcShow())
